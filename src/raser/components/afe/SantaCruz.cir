* SantaCruz: single-channel LGAD read-out board of UC Santa Cruz.
* Inverting transimpedance stage on a BFR840L3RHESD, feedback 475 Ohm,
* AC-coupled at the input and at the output.
* Ports: in (sensor side), out (to the load). Ground is node 0.
*
* After the schematic "Prototype Beam Test Board", SCIPP/UCSC, M. Wilder,
* 02/19/16, file proto_beam_test_board_V1.1C.pdf. Names there:
*   R13 = R13, C1 = C23, R1 = R14, R2 = R15, C2 = C24, C5 = C25, L1 = L4,
*   R3 = R16, C3 C4 = C27 C28, L2 = L5, C7 C8 = C35 C36.
* L2, C7 and C8 carry the values pencilled on the schematic ("replace with
* nH", "replace with 10nF") in place of the drawn 22 uH and 10 uF.
* Not in this file: the protection diodes D7 and D8 at the input, the
* calibration capacitor C22, whose value the schematic does not give, and
* the optional 3 pF shaping capacitor C26 at the output.

* definition of BFR840L3RHESD, as a subcircuit
.subckt BFR840L3RHESD 1 2 3
*
Rcx 15 1 1.57895
Rbx 25 2 1.92983
Rex 35 3 0.0800447
*
CBEPAR 22 33 1.9449E-013
CBCPAR 22 11 3.44161E-014
CCEPAR 11 33 2.24848E-013
LB    22 20 3.04259E-010
LC   11 10  2.88058E-010
CBEPCK 20 30  1E-014
CBCPCK 20 10  1.5502E-014
CCEPCK 10 30  1E-014
LBX    20 25 9.04631E-011
LEX   30 35 3.71422E-011
LCX   10 15  9.15043E-011
*
R_CS_npn 55 5 500
*
D1 33 25 M_D1
D2 5 25  M_D2
*
R_NBL_fdb 22 25 3.2
R_PS 33 5 0.03
RSUB 30 5 0.03
*
D3 5 15 M_D3
D4 23 33 M_D4
D5 23 15 M_D5
*
R_NBL_e11g 15 11 1.8
*
Q1 11 22 33 55 M_BFR840L3RHESD
*
.MODEL M_D1 D(
+ IS=3E-015
+ N=1
+ RS=2.846
+ CJO=4E-014)
*
.MODEL M_D2 D(
+ IS=3E-015
+ N=1
+ RS=4170
+ CJO=4.5E-014)
*
.MODEL M_D3 D(
+ IS=6.911E-016
+ N=1.1
+ RS=1380
+ CJO =9.5E-014)
*
.MODEL M_D4 D(
+ IS=3.5E-015
+ N=1
+ RS=0.2
+ CJO =3E-014)
*
.MODEL M_D5 D(
+ IS=3.5E-015
+ N=1.02
+ RS=4.7
+ CJO =3E-014)
*
.MODEL 	M_BFR840L3RHESD	NPN(
+	TNOM = 25
+	IS	=	2.429E-016
+	BF	=	765.7
+	NF	=	1.012
+	VAF	=	375.1
+	IKF	=	0.0819
+	ISE	=	8.827E-014
+	NE	=	2.8
+	BR	=	194
+	NR	=	0.998
+	VAR	=	1.596
+	IKR	=	0.015
+	ISC	=	1.165E-015
+	NC	=	2
+	RB	=	7.53378
+	IRB	=	0
+	RBM	=	2.1
+	RE	=	0.4405
+	RC	=	7.246
+	XTB	=	-2.276
+	EG	=	1.11
+	XTI	=	-1.233
+	CJE	=	2.23E-014
+	VJE	=	0.9214
+	MJE	=	0.5
+	TF	=	1.1E-012
+	XTF	=	5.582
+	VTF	=	0.6828
+	ITF	=	0.4491
+	PTF	=	0.0214
+	CJC	=	6.6E-015
+	VJC	=	0.7723
+	MJC	=	1.005
+	XCJC	=	0.4894
+	TR	=	1E-010
+	CJS	=	1.147E-013
+	MJS	=	1.108
+   VJS =   0.6112
+	FC	=	0.578
+	KF	=	1.65E-011
+	AF	=	1.53)
.ends BFR840L3RHESD

.subckt SantaCruz in out
VCC 8 0 dc 2.25 ; down, shift right 2
R13 in 0 1MEG ; down
C1 in 3 3.3n ; right
x1 5 3 0 BFR840L3RHESD ; npn
R1 3 4 475 ; up
R2 4 5 3k ; right
C2 4 5 3.3n ; right, shift up 1.5
C5 5 out 3.3n ; right 4
L1 5 6 47U ; up 4, shift right 1
R3 6 7 63.7 ; right
C7 8 0 10n ; down
C8 7 0 10n ; down
C3 7 0 1n ; down, shift right 2
C4 7 0 1n ; down, shift right 4
L2 8 7 2.2u ; left, shift right 4
.ends SantaCruz
